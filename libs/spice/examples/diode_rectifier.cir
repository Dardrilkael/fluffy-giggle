half-wave rectifier with RC filter
V1 in 0 SIN(0 5 1k)
D1 in out dx
C1 out 0 10u
R1 out 0 1k
.model dx D(Is=1e-14 N=1)
.tran 10u 5m 0 50u
.options itl4=50
