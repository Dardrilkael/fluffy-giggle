diode + series R: .op vs Lambert-W closed form
V1 in 0 DC 5
R1 in out 1k
D1 out 0 dx
.model dx D(Is=1e-14 N=1)
.op
