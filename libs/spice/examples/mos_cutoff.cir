NMOS cutoff: Vgs < Vth, Id ~ 0
Vgs g 0 DC 0.5
Vds d 0 DC 5
M1 d g 0 0 mn L=10u W=10u
.model mn NMOS(Vto=1 Kp=20u)
.op
