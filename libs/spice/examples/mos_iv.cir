NMOS Id vs Vds: triode-to-saturation transition
Vgs g 0 DC 2
Vds d 0 DC 0
M1 d g 0 0 mn L=10u W=10u
.model mn NMOS(Vto=1 Kp=20u Lambda=0.02)
.dc Vds 0 5 0.25
